`include "nature_fluid_dynamics.vams"
`include "disciplines.vams"
`include "constants.vams"

module channel_flow(fl_in, fl_out) ;

inout fl_in, fl_out;
fluidDynamics fl_in, fl_out;
branch (fl_in, fl_out) fl_br ;

(*desc="length", type="instance"*) parameter real length=5m;
(*desc="cross-section height", type="instance"*) parameter real height=5m;
(*desc="cross-section width", type="instance"*) parameter real width=5m;
(*desc="viscosity", type="instance"*) parameter real NU=0.0010016;

real W, H, L;
real R;

analog begin

   @(initial_step)
   begin : initial_instance
      W = width;
      H = height;
      L = length;

      R = (12*NU*L) / (1 - 0.63*(H/W)) * 1/(H*H*H*W);
   end
   Qfl(fl_br) <+ P(fl_br)/R;
end

endmodule
