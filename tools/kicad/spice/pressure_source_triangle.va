`include "nature_fluid_dynamics.vams"
`include "constants.vams"
`include "disciplines.vams"

module vclock(f_plus, f_minus);
inout f_plus, f_minus;
fluidDynamics f_plus, f_minus;

(*desc="pressure peak to peak amplitude", type="instance"*) parameter real amplitude=1k;
(*desc="pressure amplitude offset", type="instance"*) parameter real offset=0.5k;
(*desc="frequency", type="instance"*) parameter real freq=1;
(*desc="duty cycle %", type="instance"*) parameter real duty=0.5;
parameter real delay = 0.0 from [0.0:inf); //Output Waveform Delay Time.
parameter real rise = 0.01;
parameter real fall = 0.01;

real trigger, whole, range, sign;
real width; //Output Pulse Width (Duration of 'val1').
real period_1, duty_1, max_step, val0, val1, amp, rise_duty, fall_duty;

analog begin
   @(initial_step) begin
      period_1 = 1/freq;
      duty_1 = duty;
      width = duty_1 * period_1;
      rise_duty = rise*freq;
      fall_duty = fall*freq;
      val0 = amplitude/2 - offset;
      val1 = amplitude/2 + offset;
      range = ($abstime - delay)*freq;
      whole = floor(range);
      sign = 2*(whole%2)-1;
      trigger = range - whole;
      if (trigger >= 0 && trigger < rise) amp = trigger/rise;
      else if (trigger > rise && trigger <= duty) amp = 1;
      else if (trigger > duty && trigger <= duty + fall) amp = (trigger - duty)/fall;
      else amp = 0;
   end //initial_step
   P(f_plus, f_minus) <+ sign*(val0 + (val1-val0) * amp);
end //analog

endmodule
