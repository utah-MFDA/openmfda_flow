`include "nature_fluid_dynamics.vams"
`include "disciplines.vams"
`include "constants.vams"

module valve (p, n, ps, ns);
    parameter real thresh=0;	// threshold (P)
    output p, n;
    input ps, ns;
    fluidDynamics p, n, ps, ns;

    analog begin
	if (P(ps,ns) > thresh)
		P(p,n) <+ 0;
	else
		Qfl(p,n) <+ 0;
    end
endmodule
