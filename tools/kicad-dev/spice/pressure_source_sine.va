`include "nature_fluid_dynamics.vams"
`include "disciplines.vams"
`include "constants.vams"

module pressure_source_sine(fl_plus, fl_minus);
output fl_plus, fl_minus;
fluidDynamics fl_plus, fl_minus;

(*desc="pressure peak to peak amplitude", type="instance"*) parameter real amplitude=34k;
(*desc="pressure amplitude offset", type="instance"*) parameter real offset=0;
(*desc="phase offset", type="instance"*) parameter real phase=0;
(*desc="frequency", type="instance"*) parameter real freq=1;

analog begin
   P(fl_plus, fl_minus) <+ amplitude*sin(2* `M_PI *freq*$abstime+phase) + offset;
   $bound_step(0.1/freq);
end

endmodule
