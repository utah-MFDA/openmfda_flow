`include "nature_fluid_dynamics.vams"
`include "disciplines.vams"
`include "constants.vams"

module diffmix_flow(fl_i1, fl_i2, fl_out);

inout fl_i1, fl_i2, fl_out;

fluidDynamics fl_i1, fl_i2, fl_out;

//internal node
fluidDynamics int_1;

(*desc="cross-section height", type="instance"*)  parameter real height=10u*4;
(*desc="cross-section width", type="instance"*)  parameter real width=10u*14;
(*desc="viscosity", type="instance"*) parameter real NU = 0.001006;

real LENGTH1;
real LENGTH2;
real LENGTH3;

real R1_3;
real R2_3;
real R1, R2, R3;
real W, H, L1, L2, L3;

analog begin

   @(initial_step)
   begin : initial_instance
      LENGTH1=0.19m;
      LENGTH2=0.269m;
      LENGTH3=0.190m;

      W  = width;
      H  = height;
      L1 = LENGTH1;
      L2 = LENGTH2;
      L3 = LENGTH3;

      R1 = (12*NU*L1) / (1 - 0.63*(H/W)) * 1/(H*H*H*W);
      R2 = (12*NU*L2) / (1 - 0.63*(H/W)) * 1/(H*H*H*W);
      R3 = (12*NU*L3) / (1 - 0.63*(H/W)) * 1/(H*H*H*W);

      R1_3 = R1 + R3;
      R2_3 = R2 + R3;
   end // end initial_instance

   Qfl(fl_i1, int_1) <+ P(fl_i1, int_1)/R1;
   Qfl(fl_i2, int_1) <+ P(fl_i2, int_1)/R2;

   Qfl(int_1, fl_out) <+ P(int_1, fl_out)/R3;
end

endmodule
