YpressurePump soln1_dev 1 2 pressure=100k
YpressurePump soln2_dev 3 4 pressure=100k chemConcentration=1
Ychannel soln1 1 5 2 6 length=6.360000000000002m
Ychannel soln2 3 7 4 8 length=5.476000000000002m

Ychannel connect0 9 10 11 12 length=9.663819999999998m
Ychannel connect1 13 14 15 16 length=1.6819099999999985m

Ychannel out 17 0 18 19 length=2.5939099999999984m

Yp_serpentine_1 serp0 5 9 6 11 L1=360 L2=30 turns=38
Yp_serpentine_0 serp1 7 13 8 15 L1=30 L2=30 turns=1
Ydiffmix_25px_0 mix0 10 14 17 12 16 18

.tran 1m 0.1m
.print tran V(18)

.end
