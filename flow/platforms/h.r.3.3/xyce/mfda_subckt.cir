* serpentine 100px subcir

.SUBCKT serpentine_sub_100px 11 12 80 82 PARAMS: cross_sect=1

Ychannel c1 11 12 80 82 length=4.56m cross_section=cross_sect

.ENDS

* serpentine 150px subcir

.SUBCKT serpentine_sub_150px 11 12 80 82 PARAMS: cross_sect=1

Ychannel c1 11 12 80 82 length=9.576m cross_section=cross_sect

.ENDS

* serpentine 200px subcir

.SUBCKT serpentine_sub_200px 11 12 80 82 PARAMS: cross_sect=1

Ychannel c1 11 12 80 82 length=16.416m cross_section=cross_sect

.ENDS

* serpentine 200px 4 layers subcir

.SUBCKT serpentine_200px_3 11 12 80 82 PARAMS: cross_sect=1

Ychannel 11 12 80 82 length=49.248m cross_section=cross_sect

.ENDS

.SUBCKT valve_20px_1 1 2 3 4 5 6 7 8 PARAMS:

Yvalve_2 v1 1 2 3 4 5 6 7 8 cvol=0.3e-12 ct=100k

.ENDS

.SUBCKT pump_20px_0 10 11 12 13 14 15 16 17 80 81 82 83 84 85 86 87 PARAMS:

Yvalve_2 v1 10 21 12 13 80  821 82 83 cvol=0.3e-12 ct=100k
Yvalve_2 v2 21 22 14 15 821 822 84 85 cvol=0.3e-12 ct=100k
Yvalve_2 v3 22 11 16 17 822 81  86 87 cvol=0.3e-12 ct=100k

.ENDS

* p_resistor 0 subcir

.SUBCKT p_resistor_0 11 13 80 82 PARAMS: numblocks=1 wchan=14 hchan=10 w3chan=6 h3chan=5 lenchan=5 pixel_size=7.6u

Ychannel c1 11 12 80 81 length={(2*numblocks+1)*wchan*pixel_size} chan_w={lenchan*pixel_size} chan_h={hchan*pixel_size}
Ychannel c0 12 13 81 82 length={(2*numblocks)*lenchan*pixel_size} chan_w={w3chan*pixel_size} chan_h={h3chan*pixel_size}

.ENDS

* base serpentine component

.SUBCKT serpentine_base_0 11 12 81 82
.PARAM px=7.6u
.PARAM layer=10u
.PARAM turns=1
.PARAM l1=30
.PARAM l2=10
.PARAM via_h=20

Ychannel c1 11 12 81 82 length={px*(turns+1)*l1 + px*l2*turns}

.ENDS

.SUBCKT serpentine_base_1 11 14 81 84
.PARAM px=7.6u
.PARAM layer=10u
.PARAM turns=1
.PARAM l1=30
.PARAM l2=10
.PARAM via_h=20

Ychannel c1 11 12 81 82 length={px*(turns+1)*l1 + px*l2*turns}
Ychannel c2 12 13 82 83 length={layer*via_h}
Ychannel c3 13 14 83 84 length={px*(turns+1)*l1 + px*l2*turns}

.ENDS

.SUBCKT serpentine_base_2 11 16 81 86
.PARAM px=7.6u
.PARAM layer=10u
.PARAM turns=1
.PARAM l1=30
.PARAM l2=10
.PARAM via_h=20

Ychannel c1 11 12 81 82 length={px*(turns+1)*l1 + px*l2*turns}
Ychannel c2 12 13 82 83 length={layer*via_h}
Ychannel c3 13 14 83 84 length={px*(turns+1)*l1 + px*l2*turns}
Ychannel c4 14 15 84 85 length={layer*via_h}
Ychannel c5 15 16 85 86 length={px*(turns+1)*l1 + px*l2*turns}

.ENDS
