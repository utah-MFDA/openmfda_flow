YpressurePump soln1_dev 1 2 pressure=100k chemConcentration=1
YpressurePump soln2_dev 3 4 pressure=100k
YpressurePump soln3_dev 5 6 pressure=100k
Ychannel soln1 1 7 2 8 length=14.165909999999997m
Ychannel soln2 3 9 4 10 length=5.0179100000000005m
Ychannel soln3 5 11 6 12 length=6.84191m

Ychannel connect0 13 14 15 16 length=14.221909999999996m
Ychannel connect1 17 18 19 20 length=1.4539099999999987m
Ychannel connect2 21 22 23 24 length=2.1337299999999964m
Ychannel connect3 25 26 27 28 length=5.471819999999998m

Ychannel out 29 0 30 31 length=3.9619099999999987m

Yp_serpentine_3 serp0 7 13 8 15 L1=360 L2=30 turns=30
Yp_serpentine_0 serp1 9 17 10 19 L1=30 L2=30 turns=1
Yp_serpentine_0 serp2 11 21 12 23 L1=30 L2=30 turns=10
Ydiffmix_25px_0 mix0 14 18 25 16 20 27
Ydiffmix_25px_0 mix1 22 26 29 24 28 30

.tran 1m 0.1m
.print tran V(30)

.end
